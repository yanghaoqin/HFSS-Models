# Ansys Electronics Desktop project, version 2020.1
materials:
  vacuum: permittivity=1
  FR4_epoxy: permittivity=4.4 dielectric_loss_tangent=0.02
  PMLGroup1_Z_1: permittivity{anisotropic component1=1.1 component2=1.1 component3=0.45454545} permeability{anisotropic component1=1.1 component2=1.1 component3=0.45454545} dielectric_loss_tangent{anisotropic component1=1 component2=1 component3=-1} magnetic_loss_tangent{anisotropic component1=1 component2=1 component3=-1}
  PMLGroup1_XZ_1: permittivity{anisotropic component1=1 component2=0.01 component3=1} permeability{anisotropic component1=1 component2=0.01 component3=1} dielectric_loss_tangent{anisotropic component1=0 component2=242 component3=0} magnetic_loss_tangent{anisotropic component1=0 component2=242 component3=0}
  PMLGroup1_YZ_1: permittivity{anisotropic component1=0.01 component2=1 component3=1} permeability{anisotropic component1=0.01 component2=1 component3=1} dielectric_loss_tangent{anisotropic component1=242 component2=0 component3=0} magnetic_loss_tangent{anisotropic component1=242 component2=0 component3=0}
  PMLGroup1_XYZ_1: permittivity{anisotropic component1=1.1 component2=1.1 component3=1.1} permeability{anisotropic component1=1.1 component2=1.1 component3=1.1} dielectric_loss_tangent{anisotropic component1=1 component2=1 component3=1} magnetic_loss_tangent{anisotropic component1=1 component2=1 component3=1}
  PMLGroup2_Z_1: permittivity{anisotropic component1=7.2197657 component2=7.2197657 component3=0.069254325} permeability{anisotropic component1=7.2197657 component2=7.2197657 component3=0.069254325} dielectric_loss_tangent{anisotropic component1=1 component2=1 component3=-1} magnetic_loss_tangent{anisotropic component1=1 component2=1 component3=-1}
  PMLGroup2_XZ_1: permittivity{anisotropic component1=1 component2=0.01 component3=1} permeability{anisotropic component1=1 component2=0.01 component3=1} dielectric_loss_tangent{anisotropic component1=0 component2=10425.003 component3=0} magnetic_loss_tangent{anisotropic component1=0 component2=10425.003 component3=0}
  PMLGroup2_YZ_1: permittivity{anisotropic component1=0.01 component2=1 component3=1} permeability{anisotropic component1=0.01 component2=1 component3=1} dielectric_loss_tangent{anisotropic component1=10425.003 component2=0 component3=0} magnetic_loss_tangent{anisotropic component1=10425.003 component2=0 component3=0}
  PMLGroup2_XYZ_1: permittivity{anisotropic component1=7.2197657 component2=7.2197657 component3=7.2197657} permeability{anisotropic component1=7.2197657 component2=7.2197657 component3=7.2197657} dielectric_loss_tangent{anisotropic component1=1 component2=1 component3=1} magnetic_loss_tangent{anisotropic component1=1 component2=1 component3=1}
  PMLGroup3_Z_1: permittivity{anisotropic component1=8.1872657 component2=8.1872657 component3=0.06107045} permeability{anisotropic component1=8.1872657 component2=8.1872657 component3=0.06107045} dielectric_loss_tangent{anisotropic component1=1 component2=1 component3=-1} magnetic_loss_tangent{anisotropic component1=1 component2=1 component3=-1}
  PMLGroup3_XZ_1: permittivity{anisotropic component1=1 component2=0.01 component3=1} permeability{anisotropic component1=1 component2=0.01 component3=1} dielectric_loss_tangent{anisotropic component1=0 component2=13406.264 component3=0} magnetic_loss_tangent{anisotropic component1=0 component2=13406.264 component3=0}
  PMLGroup3_YZ_1: permittivity{anisotropic component1=0.01 component2=1 component3=1} permeability{anisotropic component1=0.01 component2=1 component3=1} dielectric_loss_tangent{anisotropic component1=13406.264 component2=0 component3=0} magnetic_loss_tangent{anisotropic component1=13406.264 component2=0 component3=0}
  PMLGroup3_XYZ_1: permittivity{anisotropic component1=8.1872657 component2=8.1872657 component3=8.1872657} permeability{anisotropic component1=8.1872657 component2=8.1872657 component3=8.1872657} dielectric_loss_tangent{anisotropic component1=1 component2=1 component3=1} magnetic_loss_tangent{anisotropic component1=1 component2=1 component3=1}
  Rogers RO3003 (tm): permittivity=3 dielectric_loss_tangent=0.0013
  PMLGroup3_Z_2: permittivity{anisotropic component1=8.1872657 component2=8.1872657 component3=0.06107045} permeability{anisotropic component1=8.1872657 component2=8.1872657 component3=0.06107045} dielectric_loss_tangent{anisotropic component1=1 component2=1 component3=-1} magnetic_loss_tangent{anisotropic component1=1 component2=1 component3=-1}
  PMLGroup3_XZ_2: permittivity{anisotropic component1=1 component2=0.01 component3=1} permeability{anisotropic component1=1 component2=0.01 component3=1} dielectric_loss_tangent{anisotropic component1=0 component2=13406.264 component3=0} magnetic_loss_tangent{anisotropic component1=0 component2=13406.264 component3=0}
  PMLGroup3_YZ_2: permittivity{anisotropic component1=0.01 component2=1 component3=1} permeability{anisotropic component1=0.01 component2=1 component3=1} dielectric_loss_tangent{anisotropic component1=13406.264 component2=0 component3=0} magnetic_loss_tangent{anisotropic component1=13406.264 component2=0 component3=0}
  PMLGroup3_XYZ_2: permittivity{anisotropic component1=8.1872657 component2=8.1872657 component3=8.1872657} permeability{anisotropic component1=8.1872657 component2=8.1872657 component3=8.1872657} dielectric_loss_tangent{anisotropic component1=1 component2=1 component3=1} magnetic_loss_tangent{anisotropic component1=1 component2=1 component3=1}
  PMLGroup4_Z_1: permittivity{anisotropic component1=8.3034728 component2=8.3034728 component3=0.060215769} permeability{anisotropic component1=8.3034728 component2=8.3034728 component3=0.060215769} dielectric_loss_tangent{anisotropic component1=1 component2=1 component3=-1} magnetic_loss_tangent{anisotropic component1=1 component2=1 component3=-1}
  PMLGroup4_XZ_1: permittivity{anisotropic component1=1 component2=0.01 component3=1} permeability{anisotropic component1=1 component2=0.01 component3=1} dielectric_loss_tangent{anisotropic component1=0 component2=13789.532 component3=0} magnetic_loss_tangent{anisotropic component1=0 component2=13789.532 component3=0}
  PMLGroup4_YZ_1: permittivity{anisotropic component1=0.01 component2=1 component3=1} permeability{anisotropic component1=0.01 component2=1 component3=1} dielectric_loss_tangent{anisotropic component1=13789.532 component2=0 component3=0} magnetic_loss_tangent{anisotropic component1=13789.532 component2=0 component3=0}
  PMLGroup4_XYZ_1: permittivity{anisotropic component1=8.3034728 component2=8.3034728 component3=8.3034728} permeability{anisotropic component1=8.3034728 component2=8.3034728 component3=8.3034728} dielectric_loss_tangent{anisotropic component1=1 component2=1 component3=1} magnetic_loss_tangent{anisotropic component1=1 component2=1 component3=1}
  PMLGroup3_Z_3: permittivity{anisotropic component1=8.1872657 component2=8.1872657 component3=0.06107045} permeability{anisotropic component1=8.1872657 component2=8.1872657 component3=0.06107045} dielectric_loss_tangent{anisotropic component1=1 component2=1 component3=-1} magnetic_loss_tangent{anisotropic component1=1 component2=1 component3=-1}
  PMLGroup3_XZ_3: permittivity{anisotropic component1=1 component2=0.01 component3=1} permeability{anisotropic component1=1 component2=0.01 component3=1} dielectric_loss_tangent{anisotropic component1=0 component2=13406.264 component3=0} magnetic_loss_tangent{anisotropic component1=0 component2=13406.264 component3=0}
  PMLGroup3_YZ_3: permittivity{anisotropic component1=0.01 component2=1 component3=1} permeability{anisotropic component1=0.01 component2=1 component3=1} dielectric_loss_tangent{anisotropic component1=13406.264 component2=0 component3=0} magnetic_loss_tangent{anisotropic component1=13406.264 component2=0 component3=0}
  PMLGroup3_XYZ_3: permittivity{anisotropic component1=8.1872657 component2=8.1872657 component3=8.1872657} permeability{anisotropic component1=8.1872657 component2=8.1872657 component3=8.1872657} dielectric_loss_tangent{anisotropic component1=1 component2=1 component3=1} magnetic_loss_tangent{anisotropic component1=1 component2=1 component3=1}
  PMLGroup1_Z_2: permittivity{anisotropic component1=8.2020613 component2=8.2020613 component3=0.060960285} permeability{anisotropic component1=8.2020613 component2=8.2020613 component3=0.060960285} dielectric_loss_tangent{anisotropic component1=1 component2=1 component3=-1} magnetic_loss_tangent{anisotropic component1=1 component2=1 component3=-1}
  PMLGroup1_XZ_2: permittivity{anisotropic component1=1 component2=0.01 component3=1} permeability{anisotropic component1=1 component2=0.01 component3=1} dielectric_loss_tangent{anisotropic component1=0 component2=13454.762 component3=0} magnetic_loss_tangent{anisotropic component1=0 component2=13454.762 component3=0}
  PMLGroup1_YZ_2: permittivity{anisotropic component1=0.01 component2=1 component3=1} permeability{anisotropic component1=0.01 component2=1 component3=1} dielectric_loss_tangent{anisotropic component1=13454.762 component2=0 component3=0} magnetic_loss_tangent{anisotropic component1=13454.762 component2=0 component3=0}
  PMLGroup1_XYZ_2: permittivity{anisotropic component1=8.2020613 component2=8.2020613 component3=8.2020613} permeability{anisotropic component1=8.2020613 component2=8.2020613 component3=8.2020613} dielectric_loss_tangent{anisotropic component1=1 component2=1 component3=1} magnetic_loss_tangent{anisotropic component1=1 component2=1 component3=1}
  PMLGroup4_Z_2: permittivity{anisotropic component1=6.1692755 component2=6.1692755 component3=0.081046794} permeability{anisotropic component1=6.1692755 component2=6.1692755 component3=0.081046794} dielectric_loss_tangent{anisotropic component1=1 component2=1 component3=-1} magnetic_loss_tangent{anisotropic component1=1 component2=1 component3=-1}
  PMLGroup4_XZ_2: permittivity{anisotropic component1=1 component2=0.01 component3=1} permeability{anisotropic component1=1 component2=0.01 component3=1} dielectric_loss_tangent{anisotropic component1=0 component2=7611.992 component3=0} magnetic_loss_tangent{anisotropic component1=0 component2=7611.992 component3=0}
  PMLGroup4_YZ_2: permittivity{anisotropic component1=0.01 component2=1 component3=1} permeability{anisotropic component1=0.01 component2=1 component3=1} dielectric_loss_tangent{anisotropic component1=7611.992 component2=0 component3=0} magnetic_loss_tangent{anisotropic component1=7611.992 component2=0 component3=0}
  PMLGroup4_XYZ_2: permittivity{anisotropic component1=6.1692755 component2=6.1692755 component3=6.1692755} permeability{anisotropic component1=6.1692755 component2=6.1692755 component3=6.1692755} dielectric_loss_tangent{anisotropic component1=1 component2=1 component3=1} magnetic_loss_tangent{anisotropic component1=1 component2=1 component3=1}

design Patch_77GHz_QWT (HFSS, DrivenModal, model units cm)
options: Allow_Material_Override
variables:
  # --Antenna Dimensions
  patchX = 0.146cm
  patchY = 0.0902cm
  # --Substrate Dimensions
  subH = 0.025cm
  subX = 0.5cm
  subY = 0.6cm
  # --Feed Dimensions
  InsetDistance = 0mm
  InsetGap = 0mm
  FeedWidth = 0.63mm
  FeedLength = 0.15cm
  tf4 = 0.202mm
  quarterwave = 0.648mm
geometry:
  sub [Rogers RO3003 (tm)] = box(corner=(-subX/2, -subY/2, 0cm), size=(subX, subY, subH))
  Ground = rectangle(corner=(-subX/2, -subY/2, 0cm), x_size=subX, y_size=subY)
  antenna = rectangle(corner=(-patchX/2, -patchY/2, subH), x_size=patchX, y_size=patchY)
  NewObject_MO1LYR = rectangle(corner=(-FeedWidth/2-InsetGap, patchY/2-InsetDistance, subH), x_size=FeedWidth+2*InsetGap, y_size=FeedLength)
  antenna.subtract(NewObject_MO1LYR)
  Feed_50 = rectangle(corner=(-FeedWidth/2, patchY/2-InsetDistance+quarterwave, subH), x_size=FeedWidth, y_size=FeedLength+InsetDistance)
  port1 = rectangle(corner=(-FeedWidth/2, patchY/2+FeedLength+quarterwave, 0cm), z_size=subH, x_size=FeedWidth)
  QWT = rectangle(corner=(-tf4/2, patchY/2, subH), x_size=tf4, y_size=quarterwave)
  Region [vacuum] = region(absolute_offset=1cm on all sides)
  coordinate_system FaceCS1 = face of Region: Origin=Region.vertex(1 of 8) FaceID=Region.face(+z) AxisPosn=Region.vertex(2 of 8) WhichAxis=X ZRotationAngle=0deg XOffset=0cm YOffset=0cm
  PML_Region_1 [PMLGroup4_Z_2, oriented by FaceCS1] = sweep_along_normal(Region.face(+z), length=1.1823448cm)
  coordinate_system FaceCS2 = face of Region: Origin=Region.vertex(5 of 8) FaceID=Region.face(-z) AxisPosn=Region.vertex(6 of 8) WhichAxis=X ZRotationAngle=0deg XOffset=0cm YOffset=0cm
  PML_Region_2 [PMLGroup4_Z_2, oriented by FaceCS2] = sweep_along_normal(Region.face(-z), length=1.1823448cm)
  coordinate_system FaceCS3 = face of Region: Origin=Region.vertex(4 of 8) FaceID=Region.face(-y) AxisPosn=Region.vertex(7 of 8) WhichAxis=X ZRotationAngle=0deg XOffset=0cm YOffset=0cm
  PML_Region_3 [PMLGroup4_Z_2, oriented by FaceCS3] = sweep_along_normal(Region.face(-y), length=1.1823448cm)
  coordinate_system FaceCS4 = face of Region: Origin=Region.vertex(3 of 8) FaceID=Region.face(-x) AxisPosn=Region.vertex(8 of 8) WhichAxis=X ZRotationAngle=0deg XOffset=0cm YOffset=0cm
  PML_Region_4 [PMLGroup4_Z_2, oriented by FaceCS4] = sweep_along_normal(Region.face(-x), length=1.1823448cm)
  coordinate_system FaceCS5 = face of Region: Origin=Region.vertex(2 of 8) FaceID=Region.face(+y) AxisPosn=Region.vertex(5 of 8) WhichAxis=X ZRotationAngle=0deg XOffset=0cm YOffset=0cm
  PML_Region_5 [PMLGroup4_Z_2, oriented by FaceCS5] = sweep_along_normal(Region.face(+y), length=1.1823448cm)
  coordinate_system FaceCS6 = face of Region: Origin=Region.vertex(1 of 8) FaceID=Region.face(+x) AxisPosn=Region.vertex(6 of 8) WhichAxis=X ZRotationAngle=0deg XOffset=0cm YOffset=0cm
  PML_Region_6 [PMLGroup4_Z_2, oriented by FaceCS6] = sweep_along_normal(Region.face(+x), length=1.1823448cm)
  PML_Region_7 [PMLGroup4_XZ_2, oriented by FaceCS3] = sweep_along_normal(PML_Region_1.face(at (0, -1.3, 1.61617)), length=1.1823448cm)
  PML_Region_8 [PMLGroup4_XZ_2, oriented by FaceCS4] = sweep_along_normal(PML_Region_1.face(at (-1.25, 0, 1.61617)), length=1.1823448cm)
  PML_Region_9 [PMLGroup4_XZ_2, oriented by FaceCS5] = sweep_along_normal(PML_Region_1.face(at (0, 1.3, 1.61617)), length=1.1823448cm)
  PML_Region_10 [PMLGroup4_YZ_2, oriented by FaceCS1] = sweep_along_normal(PML_Region_1.face(at (1.25, 0, 1.61617)), length=1.1823448cm)
  coordinate_system FaceCS7 = face of Region: Origin=Region.vertex(6 of 8) FaceID=Region.face(-z) AxisPosn=Region.vertex(7 of 8) WhichAxis=X ZRotationAngle=0deg XOffset=0cm YOffset=0cm
  PML_Region_11 [PMLGroup4_YZ_2, oriented by FaceCS7] = sweep_along_normal(PML_Region_2.face(at (0, -1.3, -1.59117)), length=1.1823448cm)
  coordinate_system FaceCS8 = face of Region: Origin=Region.vertex(7 of 8) FaceID=Region.face(-z) AxisPosn=Region.vertex(8 of 8) WhichAxis=X ZRotationAngle=0deg XOffset=0cm YOffset=0cm
  PML_Region_12 [PMLGroup4_YZ_2, oriented by FaceCS8] = sweep_along_normal(PML_Region_2.face(at (-1.25, 0, -1.59117)), length=1.1823448cm)
  PML_Region_13 [PMLGroup4_XZ_2, oriented by FaceCS2] = sweep_along_normal(PML_Region_2.face(at (0, 1.3, -1.59117)), length=1.1823448cm)
  PML_Region_14 [PMLGroup4_YZ_2, oriented by FaceCS2] = sweep_along_normal(PML_Region_2.face(at (1.25, 0, -1.59117)), length=1.1823448cm)
  PML_Region_15 [PMLGroup4_YZ_2, oriented by FaceCS3] = sweep_along_normal(PML_Region_3.face(at (-1.25, -1.89117, 0.0125)), length=1.1823448cm)
  PML_Region_16 [PMLGroup4_YZ_2, oriented by FaceCS6] = sweep_along_normal(PML_Region_3.face(at (1.25, -1.89117, 0.0125)), length=1.1823448cm)
  PML_Region_17 [PMLGroup4_YZ_2, oriented by FaceCS4] = sweep_along_normal(PML_Region_4.face(at (-1.84117, 1.3, 0.0125)), length=1.1823448cm)
  PML_Region_18 [PMLGroup4_YZ_2, oriented by FaceCS5] = sweep_along_normal(PML_Region_5.face(at (1.25, 1.89117, 0.0125)), length=1.1823448cm)
  PML_Region_19 [PMLGroup4_XYZ_2, oriented by FaceCS3] = sweep_along_normal(PML_Region_7.face(at (-1.25, -1.89117, 1.61617)), length=1.1823448cm)
  PML_Region_20 [PMLGroup4_XYZ_2, oriented by FaceCS1] = sweep_along_normal(PML_Region_7.face(at (1.25, -1.89117, 1.61617)), length=1.1823448cm)
  PML_Region_21 [PMLGroup4_XYZ_2, oriented by FaceCS4] = sweep_along_normal(PML_Region_8.face(at (-1.84117, 1.3, 1.61617)), length=1.1823448cm)
  PML_Region_22 [PMLGroup4_XYZ_2, oriented by FaceCS5] = sweep_along_normal(PML_Region_9.face(at (1.25, 1.89117, 1.61617)), length=1.1823448cm)
  PML_Region_23 [PMLGroup4_XYZ_2, oriented by FaceCS8] = sweep_along_normal(PML_Region_11.face(at (-1.25, -1.89117, -1.59117)), length=1.1823448cm)
  PML_Region_24 [PMLGroup4_XYZ_2, oriented by FaceCS7] = sweep_along_normal(PML_Region_11.face(at (1.25, -1.89117, -1.59117)), length=1.1823448cm)
  coordinate_system FaceCS9 = face of Region: Origin=Region.vertex(8 of 8) FaceID=Region.face(-z) AxisPosn=Region.vertex(5 of 8) WhichAxis=X ZRotationAngle=0deg XOffset=0cm YOffset=0cm
  PML_Region_25 [PMLGroup4_XYZ_2, oriented by FaceCS9] = sweep_along_normal(PML_Region_12.face(at (-1.84117, 1.3, -1.59117)), length=1.1823448cm)
  PML_Region_26 [PMLGroup4_XYZ_2, oriented by FaceCS2] = sweep_along_normal(PML_Region_13.face(at (1.25, 1.89117, -1.59117)), length=1.1823448cm)
boundaries and excitations:
  antennaMetal: Perfect E Objects=antenna
  groundMetal: Perfect E Objects=Ground
  PerfE1: Perfect E Objects=Feed_50
  PerfE2: Perfect E Objects=QWT
  PML_radiation1: Radiation Faces=Region.face(+z) IsForPML
  PML_radiation2: Radiation Faces=Region.face(-z) IsForPML
  PML_radiation3: Radiation Faces=Region.face(-y) IsForPML
  PML_radiation4: Radiation Faces=Region.face(-x) IsForPML
  PML_radiation5: Radiation Faces=Region.face(+y) IsForPML
  PML_radiation6: Radiation Faces=Region.face(+x) IsForPML
  1: Lumped Port Faces=port1.face Modes{Mode1{IntLine{middle of port1.edge(z at corner) -> middle of port1.edge(z opposite corner)} CharImp=Zpi}} Impedance=50ohm
  reference conductors: antenna
setups:
  Setup1: HfssDriven Frequency=79GHz MaxDeltaS=0.02 MaximumPasses=20 MinimumPasses=1 MinimumConvergedPasses=1 PercentRefinement=30 BasisOrder=1 PortAccuracy=2
    sweep Sweep: 77GHz to 81GHz, 62 points; disabled Type=Interpolating SaveFields InterpTolerance=0.5 InterpMaxSolns=250 InterpUsePortImped=false PassivityErrorTolerance=0.0001
source amplitudes:
  1:1: 1W 0deg

design Patch_77GHz_Inset (HFSS, DrivenModal, model units cm)
options: Allow_Material_Override
variables:
  # --Antenna Dimensions
  patchX = 0.146cm
  patchY = 0.0961cm
  # --Substrate Dimensions
  subH = 0.025cm
  subX = 0.4cm
  subY = 0.5cm
  # --Feed Dimensions
  InsetDistance = 0.18mm
  InsetGap = 0.1mm
  FeedWidth = 0.3mm
  FeedLength = 0.15cm
  tf4 = 0.202mm
  quarterwave = 0.648mm
geometry:
  sub [Rogers RO3003 (tm)] = box(corner=(-subX/2, -subY/2, 0cm), size=(subX, subY, subH))
  Ground = rectangle(corner=(-subX/2, -subY/2, 0cm), x_size=subX, y_size=subY)
  antenna = rectangle(corner=(-patchX/2, -patchY/2, subH), x_size=patchX, y_size=patchY)
  NewObject_MO1LYR = rectangle(corner=(-FeedWidth/2-InsetGap, patchY/2-InsetDistance, subH), x_size=FeedWidth+2*InsetGap, y_size=FeedLength)
  antenna.subtract(NewObject_MO1LYR)
  Feed = rectangle(corner=(-FeedWidth/2, patchY/2-InsetDistance, subH), x_size=FeedWidth, y_size=FeedLength+InsetDistance)
  port1 = rectangle(corner=(-FeedWidth/2, patchY/2+FeedLength, 0cm), z_size=subH, x_size=FeedWidth)
  Region [vacuum] = region(absolute_offset=2mm on all sides)
  coordinate_system FaceCS1 = face of Region: Origin=Region.vertex(1 of 8) FaceID=Region.face(+z) AxisPosn=Region.vertex(2 of 8) WhichAxis=X ZRotationAngle=0deg XOffset=0cm YOffset=0cm
  PML_Region_1 [PMLGroup4_Z_1, oriented by FaceCS1] = sweep_along_normal(Region.face(+z), length=0.34168153cm)
  coordinate_system FaceCS2 = face of Region: Origin=Region.vertex(5 of 8) FaceID=Region.face(-z) AxisPosn=Region.vertex(6 of 8) WhichAxis=X ZRotationAngle=0deg XOffset=0cm YOffset=0cm
  PML_Region_2 [PMLGroup4_Z_1, oriented by FaceCS2] = sweep_along_normal(Region.face(-z), length=0.34168153cm)
  coordinate_system FaceCS3 = face of Region: Origin=Region.vertex(4 of 8) FaceID=Region.face(-y) AxisPosn=Region.vertex(7 of 8) WhichAxis=X ZRotationAngle=0deg XOffset=0cm YOffset=0cm
  PML_Region_3 [PMLGroup4_Z_1, oriented by FaceCS3] = sweep_along_normal(Region.face(-y), length=0.34168153cm)
  coordinate_system FaceCS4 = face of Region: Origin=Region.vertex(3 of 8) FaceID=Region.face(-x) AxisPosn=Region.vertex(8 of 8) WhichAxis=X ZRotationAngle=0deg XOffset=0cm YOffset=0cm
  PML_Region_4 [PMLGroup4_Z_1, oriented by FaceCS4] = sweep_along_normal(Region.face(-x), length=0.34168153cm)
  coordinate_system FaceCS5 = face of Region: Origin=Region.vertex(2 of 8) FaceID=Region.face(+y) AxisPosn=Region.vertex(5 of 8) WhichAxis=X ZRotationAngle=0deg XOffset=0cm YOffset=0cm
  PML_Region_5 [PMLGroup4_Z_1, oriented by FaceCS5] = sweep_along_normal(Region.face(+y), length=0.34168153cm)
  coordinate_system FaceCS6 = face of Region: Origin=Region.vertex(1 of 8) FaceID=Region.face(+x) AxisPosn=Region.vertex(6 of 8) WhichAxis=X ZRotationAngle=0deg XOffset=0cm YOffset=0cm
  PML_Region_6 [PMLGroup4_Z_1, oriented by FaceCS6] = sweep_along_normal(Region.face(+x), length=0.34168153cm)
  PML_Region_7 [PMLGroup4_XZ_1, oriented by FaceCS3] = sweep_along_normal(PML_Region_1.face(at (0, -0.45, 0.395841)), length=0.34168153cm)
  PML_Region_8 [PMLGroup4_XZ_1, oriented by FaceCS4] = sweep_along_normal(PML_Region_1.face(at (-0.4, 0, 0.395841)), length=0.34168153cm)
  PML_Region_9 [PMLGroup4_XZ_1, oriented by FaceCS5] = sweep_along_normal(PML_Region_1.face(at (0, 0.45, 0.395841)), length=0.34168153cm)
  PML_Region_10 [PMLGroup4_YZ_1, oriented by FaceCS1] = sweep_along_normal(PML_Region_1.face(at (0.4, 0, 0.395841)), length=0.34168153cm)
  coordinate_system FaceCS7 = face of Region: Origin=Region.vertex(6 of 8) FaceID=Region.face(-z) AxisPosn=Region.vertex(7 of 8) WhichAxis=X ZRotationAngle=0deg XOffset=0cm YOffset=0cm
  PML_Region_11 [PMLGroup4_YZ_1, oriented by FaceCS7] = sweep_along_normal(PML_Region_2.face(at (0, -0.45, -0.370841)), length=0.34168153cm)
  coordinate_system FaceCS8 = face of Region: Origin=Region.vertex(7 of 8) FaceID=Region.face(-z) AxisPosn=Region.vertex(8 of 8) WhichAxis=X ZRotationAngle=0deg XOffset=0cm YOffset=0cm
  PML_Region_12 [PMLGroup4_YZ_1, oriented by FaceCS8] = sweep_along_normal(PML_Region_2.face(at (-0.4, 0, -0.370841)), length=0.34168153cm)
  PML_Region_13 [PMLGroup4_XZ_1, oriented by FaceCS2] = sweep_along_normal(PML_Region_2.face(at (0, 0.45, -0.370841)), length=0.34168153cm)
  PML_Region_14 [PMLGroup4_YZ_1, oriented by FaceCS2] = sweep_along_normal(PML_Region_2.face(at (0.4, 0, -0.370841)), length=0.34168153cm)
  PML_Region_15 [PMLGroup4_YZ_1, oriented by FaceCS3] = sweep_along_normal(PML_Region_3.face(at (-0.4, -0.620841, 0.0125)), length=0.34168153cm)
  PML_Region_16 [PMLGroup4_YZ_1, oriented by FaceCS6] = sweep_along_normal(PML_Region_3.face(at (0.4, -0.620841, 0.0125)), length=0.34168153cm)
  PML_Region_17 [PMLGroup4_YZ_1, oriented by FaceCS4] = sweep_along_normal(PML_Region_4.face(at (-0.570841, 0.45, 0.0125)), length=0.34168153cm)
  PML_Region_18 [PMLGroup4_YZ_1, oriented by FaceCS5] = sweep_along_normal(PML_Region_5.face(at (0.4, 0.620841, 0.0125)), length=0.34168153cm)
  PML_Region_19 [PMLGroup4_XYZ_1, oriented by FaceCS3] = sweep_along_normal(PML_Region_7.face(at (-0.4, -0.620841, 0.395841)), length=0.34168153cm)
  PML_Region_20 [PMLGroup4_XYZ_1, oriented by FaceCS1] = sweep_along_normal(PML_Region_7.face(at (0.4, -0.620841, 0.395841)), length=0.34168153cm)
  PML_Region_21 [PMLGroup4_XYZ_1, oriented by FaceCS4] = sweep_along_normal(PML_Region_8.face(at (-0.570841, 0.45, 0.395841)), length=0.34168153cm)
  PML_Region_22 [PMLGroup4_XYZ_1, oriented by FaceCS5] = sweep_along_normal(PML_Region_9.face(at (0.4, 0.620841, 0.395841)), length=0.34168153cm)
  PML_Region_23 [PMLGroup4_XYZ_1, oriented by FaceCS8] = sweep_along_normal(PML_Region_11.face(at (-0.4, -0.620841, -0.370841)), length=0.34168153cm)
  PML_Region_24 [PMLGroup4_XYZ_1, oriented by FaceCS7] = sweep_along_normal(PML_Region_11.face(at (0.4, -0.620841, -0.370841)), length=0.34168153cm)
  coordinate_system FaceCS9 = face of Region: Origin=Region.vertex(8 of 8) FaceID=Region.face(-z) AxisPosn=Region.vertex(5 of 8) WhichAxis=X ZRotationAngle=0deg XOffset=0cm YOffset=0cm
  PML_Region_25 [PMLGroup4_XYZ_1, oriented by FaceCS9] = sweep_along_normal(PML_Region_12.face(at (-0.570841, 0.45, -0.370841)), length=0.34168153cm)
  PML_Region_26 [PMLGroup4_XYZ_1, oriented by FaceCS2] = sweep_along_normal(PML_Region_13.face(at (0.4, 0.620841, -0.370841)), length=0.34168153cm)
boundaries and excitations:
  antennaMetal: Perfect E Objects=antenna
  groundMetal: Perfect E Objects=Ground
  PerfE1: Perfect E Objects=Feed
  PML_radiation1: Radiation Faces=Region.face(+z) IsForPML
  PML_radiation2: Radiation Faces=Region.face(-z) IsForPML
  PML_radiation3: Radiation Faces=Region.face(-y) IsForPML
  PML_radiation4: Radiation Faces=Region.face(-x) IsForPML
  PML_radiation5: Radiation Faces=Region.face(+y) IsForPML
  PML_radiation6: Radiation Faces=Region.face(+x) IsForPML
  1: Lumped Port Faces=port1.face Modes{Mode1{IntLine{middle of port1.edge(z at corner) -> middle of port1.edge(z opposite corner)} CharImp=Zpi}} Impedance=50ohm
  reference conductors: antenna
setups:
  Setup1: HfssDriven Frequency=77GHz MaxDeltaS=0.02 MaximumPasses=20 MinimumPasses=1 MinimumConvergedPasses=1 PercentRefinement=30 BasisOrder=1 PortAccuracy=2
    sweep Sweep: 77GHz to 81GHz, 61 points; Type=Interpolating SaveFields InterpTolerance=0.5 InterpMaxSolns=250 InterpUsePortImped=false PassivityErrorTolerance=0.0001
source amplitudes:
  1:1: 1W 0deg
radiation setups:
  Infinite Sphere1: Infinite Sphere Theta=-180deg..180deg step 2deg Phi=-180deg..180deg step 2deg
field plots:
  Mag_E1: E Field over Feed.face antenna.face(at (0, 0, 0.025)) on Setup1 : LastAdaptive at Freq=77GHz Phase=0deg
reports:
  S Parameter Plot 1: dB(S(1,1)) vs Freq on Setup1 : Sweep
  Z Parameter Plot 1: re(Z(1,1)), im(Z(1,1)) vs Freq on Setup1 : Sweep; markers MX1 at x=7.9345e+10
  Gain Plot 1: dB(GainTotal) vs Phi, Theta on Setup1 : LastAdaptive, Infinite Sphere1 [Freq=77GHz]
  Gain Plot 2: dB(GainPhi) vs Phi on Setup1 : LastAdaptive, Infinite Sphere1 [Theta=90deg Freq=77GHz]; dB(GainTheta) vs Theta on Setup1 : LastAdaptive, Infinite Sphere1 [Phi=0deg Freq=77GHz]
